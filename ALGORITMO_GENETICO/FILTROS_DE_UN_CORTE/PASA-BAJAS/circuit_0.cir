.title CIRCUIT PASABAJAS 2DO ORDEN MFB
Vs 1000 0 AC 5

Rs 1000 1 470
Rl 1002 0 470

R1 1 2 4.7e+1
R_fb 2 3 4.7e+4
R_out 1002 2 4.7e+2
C1 2 0 6.8e-7
C2 3 1002 2.2e-9

Vpp Vp 0 DC 15
Vnn Vn 0 DC -15
XOP 0 3 Vp Vn 1002 LM741

.INCLUDE lm741.lib
.AC DEC 100 1 1e8

.control
run
wrdata datos_filtro.txt vm(1002)
write simulation_0.raw
.endc
.END
