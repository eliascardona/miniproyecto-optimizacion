.title CIRCUIT PASABANDA 2DO ORDEN MFB
Vs 1000 0 AC 5

Rs 1000 1 470
Rl 1002 0 470

R_gnd 1 0 1.5e+1
C1 1 2 4.7e-6
C2 1002 1 2.2e-6
R_fb 1002 2 6.8e+2

Vpp Vp 0 DC 15
Vnn Vn 0 DC -15
XOP 0 2 Vp Vn 1002 LM741

.INCLUDE lm741.lib
.AC DEC 100 1 1e7

.control
run
wrdata datos_filtro.txt vm(1002)
write simulation_0.raw
.endc
.END
