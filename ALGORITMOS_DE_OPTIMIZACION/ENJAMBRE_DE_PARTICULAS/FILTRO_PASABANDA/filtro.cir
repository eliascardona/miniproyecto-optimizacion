.title FILTRO PASA BANDA 4TO ORDEN (HP + LP)
Vs 1000 0 AC 5.0
Rs 1000 1 1000.0

* --- ETAPA 1: PASA ALTAS (Frecuencia de corte inferior) ---
C1_HP 1 2 3.3e-7
C2_HP 2 3 4.7e-7
R1_HP 2 1001 4.7e+2
R2_HP 3 0 5.6e+3
* Conexiones LM741: In+(3) In-(1001) Vp(Vp) Vn(Vn) Out(1001)
XOP1 3 1001 Vp Vn 1001 LM741

* --- ETAPA 2: PASA BAJAS (Frecuencia de corte superior) ---
R1_LP 1001 4 1.5e+3
R2_LP 4 5 2.7e+3
C1_LP 4 1002 3.3e-8
C2_LP 5 0 1.0e-8
* Conexiones LM741: In+(5) In-(1002) Vp(Vp) Vn(Vn) Out(1002)
XOP2 5 1002 Vp Vn 1002 LM741

* Fuentes de Alimentacion y Carga
Vpp Vp 0 DC 15.0
Vnn Vn 0 DC -15.0
Rl 1002 0 12000.0

.INCLUDE lm741.lib
.AC DEC 100 1 100000

.control
run
wrdata datos_filtro.txt vm(1002)
write simulacion.raw
.endc
.END
