.title FILTRO PASA BAJAS 4TO ORDEN SALLEN-KEY
Vs 1000 0 AC 5.0
Rs 1000 1 470.0

* --- ETAPA 1 ---
R1_1 1 2 4.7e+3
R2_1 2 3 4.7e+3
C1_1 2 1001 6.8e-9
C2_1 3 0 1.5e-9
* Conexiones LM741: In+(3) In-(1001) Vp(Vp) Vn(Vn) Out(1001)
XOP1 3 1001 Vp Vn 1001 LM741

* --- ETAPA 2 ---
R1_2 1001 4 1.0e+1
R2_2 4 5 3.3e+1
C1_2 4 1002 1.0e-9
C2_2 5 0 4.7e-7
* Conexiones LM741: In+(5) In-(1002) Vp(Vp) Vn(Vn) Out(1002)
XOP2 5 1002 Vp Vn 1002 LM741

* Fuentes de Alimentacion y Carga
Vpp Vp 0 DC 15.0
Vnn Vn 0 DC -15.0
Rl 1002 0 4700.0

.INCLUDE lm741.lib
.AC DEC 100 100 100000

.control
run
wrdata datos_filtro.txt vm(1002)
write simulacion.raw
.endc
.END
